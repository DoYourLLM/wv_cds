; wv_cds_probe.il - probe, in the schematic, the nets wv is displaying
;
; Called at the end of a "Send to WV (Direct)" click. The names come from
; wv_cds_names.py (in python/), which asks wv what it is still showing, and
; each one gets a net probe:
;
;   geAddNetProbe(win nil "/I0/I1/n1")
;
; geAddNetProbe wants a slash path - the reference says "The string should be
; in the format of /instname/instname/.../objectName" - while the names coming
; out of wv use the dotted form (I0.n1), so wvCdsProbeNet converts.
;
; Checked against the IC23.1 SKILL Reference (skdfref):
;   geAddNetProbe( [w_windowId] [l_lpp] [lt_probeSpec] ) => o_probe
;   geDeleteAllProbe( [w_windowId] [g_crossProbeFlag] ) => t / nil
;
; Written with prog + if + foreach only. NOT when/unless/cond: the reference
; gives those a single body expression each -
;   when( g_condition g_expr1 )      unless( g_condition g_expr1 )
; - and hand-writing them with several bodies (or hand-rolling cond, whose
; signature is cond( l_clause1 ), a single list of clauses) is what produced
; "eval: not a function - !names" earlier. prog takes several expressions, so
; straight-line code is both legal and readable.
;
; Verified with:
;   check_new_functions.py wv_cds_probe.il --strict \
;     --allow runSyncIPC,wvCdsPython
;   (runSyncIPC is in wv_cds_ipc.il, so the checker cannot see it here)

; The interpreter used for the python/ helpers: $WV_CDS_PYTHON when it is
; exported, otherwise whatever python3 resolves to. Same rule as
; wv_cds_gui_start.sh.
procedure(wvCdsPython()
  let((p)
    p = getShellEnvVar("WV_CDS_PYTHON")
    if(p p "python3")))

; Add one net probe for the signal name nm, in window win.
; Returns the probe object, or nil when nothing was added.
procedure(wvCdsProbeNet(win nm)
  prog((path parts r hit x mapped)
    hit = nil
    if(stringp(nm)
      then
        ; A device current is not a net. Its probe path is the instance
        ; terminal, "/I0/I1/R2/PLUS", and it is found in two steps: the table
        ; wv_cds_instpin.il filled in while the terminal was selected, and -
        ; when that has nothing, because wv is showing a name this session
        ; never plotted - the same path worked out from the schematic.
        mapped = wvCdsInstProbePath(nm)
        unless(mapped
          ; Not in the table. Either this session never plotted it - a name
          ; typed into wv by hand, or one left over from an earlier Virtuoso -
          ; or wv is showing a current under a name of its own. Work the path
          ; out from the schematic then, the way the reference script does.
          mapped = wvCdsInstProbePathFromSch(win nm))
        if(mapped
          then
            path = mapped
          else
            if(rexMatchp(":[0-9*]+$" nm)
              then
                ; A device current whose path could not be worked out. Sending
                ; the name on as a path is what produced
                ; "GE-2133: The object R1:1 does not exist in cellview ...":
                ; say what really happened rather than ask for a net that
                ; cannot exist.
                warn("wvCds: %s looks like a device current, but no probe path for it was found - skipped\n" nm)
                return(nil)
              else
                path = ""
                parts = parseString(nm ".")
                foreach(x parts
                  path = strcat(path "/" x)
                )
            )
        )
        r = errset(geAddNetProbe(win nil path))
        hit = car(r)
        if(hit
          then printf("wvCds: probe %s -> %s\n" nm path)
          else printf("wvCds: probe FAILED %s -> %s\n" nm path)
        )
    )
    return(hit)
  )
)

; Clear the probes in win, then create one per name.
; Returns the number of probes that were actually created.
;
; The clear is unconditional once a list has arrived: it is what makes a net
; that is no longer in wv lose its probe. It also removes probes you placed by
; hand in that window - the caller only reaches this point when wv really did
; report a list, so a failed click never clears anything.
procedure(wvCdsProbeNames(win names)
  prog((n nm)
    n = 0
    if(win == nil
      then
        warn("wvCds: no schematic window - nothing probed\n")
        return(n)
    )
    ; names may be nil, and that is NOT "do nothing". The caller only reaches
    ; this point when wv answered, so an empty list means every signal this
    ; tool plotted is gone from wv - and then every probe here goes too.
    ;
    ; An early return used to sit here and made "you deleted everything in wv"
    ; behave exactly like "wv never answered": the probes stayed. The count
    ; prefix exists to keep those two apart in the caller; collapsing them
    ; again in here threw that away.
    errset(geDeleteAllProbe(win))
    foreach(nm names
      if(wvCdsProbeNet(win nm)
        then n = n + 1
      )
    )
    printf("wvCds: cleared the window, then probed %d of %d net(s)\n"
           n length(names))
    return(n)
  )
)

; Ask wv which signals it is still displaying.
;
; Returns nil when wv did not answer, and otherwise the reply as a token list
; whose FIRST element is the count:
;
;   ("0")                     wv answered; this tool has nothing on screen
;   ("3" "I0.n1" "VDD" "n2")  wv answered; those three are on screen
;
; The count is in the reply precisely so the two cases can be told apart: an
; empty reply and a "refused" reply are both nil here, so without it "nothing
; is displayed any more" (clear the probes) would look identical to "wv is not
; answering" (leave the probes alone). The caller drops the count with cdr.
;
; The names are echoed to the CIW as they arrive, before anything is probed:
; when a probe comes back FAILED this is what says whether wv handed us a name
; that does not exist in this schematic, or nothing at all.
procedure(wvCdsDisplayedNames()
  prog((r tok names)
    r = runSyncIPC(sprintf(nil "%s %s/python/wv_cds_names.py"
                             wvCdsPython() WV_CDS_SH_DIR))
    tok = car(r)
    if(tok
      then
        if(rexMatchp("^refused" tok)
          then r = nil
          else
            names = cdr(r)
            printf("wvCds: wv is showing %d signal(s): %L\n"
                   length(names) names)
        )
    )
    return(r)
  )
)

; The command the Python GUI sends over the skill server (see
; wv_cds_skill_server.il) after it has finished plotting, so the schematic gets
; the probes too. The GUI is a separate process and cannot touch the schematic
; itself; this runs inside Virtuoso instead.
;
; The skill server evaluates commands from the CIW's context, so there is no
; right-click window here - take the current one. Unlike the Direct path there
; is no way to know which schematic the user meant, so a window that is not
; probeable is refused rather than guessed at.
;
; Same rule as everything else: nil from wvCdsDisplayedNames means wv did not
; answer, and then the probes are left exactly as they were.
procedure(wvCdsProbeFromGui()
  prog((win names)
    win = hiGetCurrentWindow()
    if(win == nil
      then
        warn("wvCds: no current window - probes left as they were\n")
        return(nil)
    )
    names = wvCdsDisplayedNames()
    if(names
      then
        wvCdsProbeNames(win cdr(names))
      else
        warn("wvCds: wv did not answer - probes left as they were\n")
    )
    return(names)
  )
)

printf("wv_cds_probe.il loaded\n")
